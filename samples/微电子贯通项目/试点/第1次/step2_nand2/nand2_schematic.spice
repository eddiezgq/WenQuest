* 贯通项目步骤二：二输入与非门的原理图网表（LVS 用）。也可以在 Xschem 里画原理图，用 wqlab netlist 导出。
* 端口顺序不要改：A B OUT VDD VSS。器件写法照第 1 章反相器（ch1/inv.spice），管宽要和版图一致。
.subckt nand2 A B OUT VDD VSS
* 两个串联的 NMOS（中间节点 X）：VSS - N1(A) - X - N2(B) - OUT
XN1 X A VSS VSS sky130_fd_pr__nfet_01v8 W=0.42 L=0.15 nf=1 m=1
XN2 OUT B X VSS sky130_fd_pr__nfet_01v8 W=0.42 L=0.15 nf=1 m=1
* 两个并联的 PMOS
XP1 OUT A VDD VDD sky130_fd_pr__pfet_01v8 W=0.97 L=0.15 nf=1 m=1
XP2 OUT B VDD VDD sky130_fd_pr__pfet_01v8 W=0.97 L=0.15 nf=1 m=1
.ends
